ADE simulation setup
Test ece483_sp23_ldo_model_1: ece483_sp23/ldo_model/schematic, simulator spectre
  Models: /class/ece483/models/models_ece483
  Variables: Lp = 270n; Wp = 1u; Aea = 10; Co1 = 200f; Cout = 200p; Gm1 = 100u; Iload = 1m; Rf1 = 1k; Rf2 = 1k; VIN = 1.8; vin = 1; VREF = 0.6; vref = 0
  Temperature: 27
  Analysis noise: start=1k stop=10G dec=100 p=/Vout n=/gnd!
  Analysis tran: stop=20u errpreset=moderate
  Analysis dc: (saves the operating point)
  Analysis stb: start=1 stop=10G probe=/VSTB stbProbeMode=differential
  Output Loop Gain Phase = phaseDegUnwrapped(getData("loopGain" ?result "stb"))
  Output Loop Gain dB20 = db(mag(getData("loopGain" ?result "stb")))
  Output Phase Margin = getData("phaseMargin" ?result "stb_margin")
  Output Gain Margin = getData("gainMargin" ?result "stb_margin")
  Output Vout_dc = VS("/Vout")
  Output output noise; V**2 / Hz = (getData("out" ?result "noise")**2)
  Output Line Reg = (deriv(VS("/Vout")) / deriv(VS("/Vin")))
  Output Vin_dc = VS("/Vin")
  Output Vout_trans = VT("/Vout")
Run mode: Single Run, Sweeps and Corners
Setup values for test ece483_sp23_ldo_model_1: vin = 0
