ADE simulation setup
Test ece483_sp23_ldo_model_1: ece483_sp23/ldo_model/schematic, simulator spectre
  Models: /class/ece483/models/models_ece483
  Variables: Cc = 0; VIN = 1.8; Rf1 = 1.5k; vin = 1; Gm1 = 100u; Co1 = 200f; Aea = 10; Lp = 270n; vref = 0; Rf2 = 1k; Cout = 200p; VREF = 600m; Iload = 0.1m; Wp = 1u
  Temperature: 27
  Analysis dc: sweep VIN start=1.62m stop=1.98m (saves the operating point)
  Analysis noise: start=1k stop=10G dec=100 p=/Vout n=/gnd!
  Analysis tran: stop=20u errpreset=moderate
  Analysis stb: start=1 stop=10G probe=/VSTB stbProbeMode=differential
  Output Loop Gain Phase = phaseDegUnwrapped(getData("loopGain" ?result "stb"))
  Output Loop Gain dB20 = db(mag(getData("loopGain" ?result "stb")))
  Output Phase Margin = getData("phaseMargin" ?result "stb_margin")
  Output Gain Margin = getData("gainMargin" ?result "stb_margin")
  Output Vout_dc = VS("/Vout")
  Output output noise; V**2 / Hz = (getData("out" ?result "noise")**2)
  Output Line Reg = (deriv(VS("/Vout")) / deriv(VS("/Vin"))) (unticked)
  Output Vin_dc = VS("/Vin")
  Output Vout_trans = VT("/Vout")
  Output V/V /Vin; dc (V/V) = (v("/Vout" ?result "dc") / v("/Vin" ?result "dc"))
  Output waveVsWave(?x OS("/OTA_DM/N0" "gmoverid") ?y (OS("/OTA_DM/N0" "id") / VAR("W_sweep")))
  Output v /Vout; dc (V) = v("/Vout" ?result "dc")
Run mode: Single Run, Sweeps and Corners
Setup values for test ece483_sp23_ldo_model_1: Iload = 1m; Rf1 = 1k; vin = 0; VREF = 0.6
