ADE simulation setup
Run mode: Single Run, Sweeps and Corners
Tests:
  ece483_sp23_ldo_model_1: ece483_sp23/ldo_model/schematic, simulator spectre
    Variables: Aea = 10; Co1 = 200f; Cout = 200p; Gm1 = 100u; Iload = 0.1m; Rf1 = 1.5k; Rf2 = 1k; VIN = 1.8; vin = 1; VREF = 600m; vref = 0; Lp = 270n; Wp = 1u; Cc = 0
    Outputs: Vout_dc; Line Reg; Vin_dc; Vout_trans; V/V /Vin; dc (V/V)
